* OR1 standard cell reference netlist (CDL)
* Source: mineda-support/OpenRule1um tech/tech/models/ishi-kai-lib/stdcells_lvs/*.lib
*         commit 85dbacfb05351c5116158f4d8e0d5c995d3b4ad1
* Device sizes match the shipped layouts (magic extract of the GDS:
* INVX1 6/2, BUFX2 3x6/3x2, NAND2X1 2x6/2x2, NOR2X1 2x6/2x2, DFFPOSX1 14x6/14x2).
* Port names follow the OR1 LEF (X -> Y, CK -> CLK).

.subckt BUFX2 VDD A Y VSS
M4 Y net13 VDD VDD pfet w=6u l=1u
M3 Y net13 VDD VDD pfet w=6u l=1u
M2 net13 A VDD VDD pfet w=6u l=1u
M5 Y net13 VSS VSS nfet w=2u l=1u
M1 net13 A VSS VSS nfet w=2u l=1u
M0 Y net13 VSS VSS nfet w=2u l=1u
.ends BUFX2

.subckt INVX1 VDD A Y VSS
M3 Y A VDD VDD pfet w=6u l=1u
M0 Y A VSS VSS nfet w=2u l=1u
.ends INVX1

.subckt NAND2X1 VDD Y A B VSS
M4 N001 A VSS VSS nfet w=2u l=1u
M3 Y B N001 VSS nfet w=2u l=1u
M1 Y B VDD VDD pfet w=6u l=1u
M0 Y A VDD VDD pfet w=6u l=1u
.ends NAND2X1

.subckt NOR2X1 VDD B Y A VSS
M3 N001 A VDD VDD pfet w=6u l=1u
M2 Y B N001 VDD pfet w=6u l=1u
M1 Y B VSS VSS nfet w=2u l=1u
M0 Y A VSS VSS nfet w=2u l=1u
.ends NOR2X1

.subckt DFFPOSX1 VDD VSS CLK D Q QB
M26 Q QB VDD VDD pfet w=6u l=1u
M24 QB net92 VDD VDD pfet w=6u l=1u
M18 net78 net116 N003 VDD pfet w=6u l=1u
M17 net78 net74 N004 VDD pfet w=6u l=1u
M16 N003 net104 VDD VDD pfet w=6u l=1u
M15 N004 net92 VDD VDD pfet w=6u l=1u
M14 net92 net78 VDD VDD pfet w=6u l=1u
M13 net104 net114 VDD VDD pfet w=6u l=1u
M12 N002 net104 VDD VDD pfet w=6u l=1u
M11 N001 D VDD VDD pfet w=6u l=1u
M10 net114 net116 N002 VDD pfet w=6u l=1u
M9 net114 net74 N001 VDD pfet w=6u l=1u
M8 net116 net74 VDD VDD pfet w=6u l=1u
M7 net74 CLK_I VDD VDD pfet w=6u l=1u
M27 Q QB VSS VSS nfet w=2u l=1u
M25 QB net92 VSS VSS nfet w=2u l=1u
M23 net78 net74 N007 VSS nfet w=2u l=1u
M22 N007 net104 VSS VSS nfet w=2u l=1u
M21 net78 net116 N008 VSS nfet w=2u l=1u
M20 N008 net92 VSS VSS nfet w=2u l=1u
M19 net92 net78 VSS VSS nfet w=2u l=1u
M6 net116 net74 VSS VSS nfet w=2u l=1u
M5 net74 CLK_I VSS VSS nfet w=2u l=1u
M4 net104 net114 VSS VSS nfet w=2u l=1u
M3 N006 net104 VSS VSS nfet w=2u l=1u
M2 net114 net74 N006 VSS nfet w=2u l=1u
M1 N005 D VSS VSS nfet w=2u l=1u
M0 net114 net116 N005 VSS nfet w=2u l=1u

M_inv_p CLK_I CLK VDD VDD pfet w=6u l=1u
M_inv_n CLK_I CLK VSS VSS nfet w=2u l=1u
.ends DFFPOSX1

.subckt FILL VDD VSS
.ends FILL

.subckt FILL_05 VDD VSS
.ends FILL_05

.subckt FILL_10 VDD VSS
.ends FILL_10

.subckt FILL_15 VDD VSS
.ends FILL_15

.subckt FILL_20 VDD VSS
.ends FILL_20

.subckt FILL_25 VDD VSS
.ends FILL_25

.subckt TAP VDD VSS
.ends TAP

.subckt TIEHI VDD VSS Y
M0 Y VSS VDD VDD pfet w=2u l=1u
.ends TIEHI

.subckt TIELO VDD VSS Y
M0 Y VDD VSS VSS nfet w=2u l=1u
.ends TIELO

.subckt DECAPX1 VDD VSS
C1 VDD VSS 12f MOSCAP
.ends DECAPX1

.subckt ENDCAPX1 VDD VSS
.ends ENDCAPX1

.subckt ANTENNAX1 VDD VSS DIODE
.ends ANTENNAX1

.subckt CLKBUFX2 VDD A Y VSS
M4 Y net13 VDD VDD pfet w=6u l=1u
M3 Y net13 VDD VDD pfet w=6u l=1u
M2 net13 A VDD VDD pfet w=6u l=1u
M5 Y net13 VSS VSS nfet w=2u l=1u
M1 net13 A VSS VSS nfet w=2u l=1u
M0 Y net13 VSS VSS nfet w=2u l=1u
.ends CLKBUFX2

.subckt DFFRX1 VDD VSS CLK D Q QB RESET
M26 Q QB VDD VDD pfet w=6u l=1u
M24 QB net92 VDD VDD pfet w=6u l=1u
M18 net78 net116 N003 VDD pfet w=6u l=1u
M17 net78 net74 N004 VDD pfet w=6u l=1u
M16 N003 net104 VDD VDD pfet w=6u l=1u
M15 N004 net92 VDD VDD pfet w=6u l=1u
M14 net92 net78 VDD VDD pfet w=6u l=1u
M13 net104 net114 VDD VDD pfet w=6u l=1u
M12 N002 net104 VDD VDD pfet w=6u l=1u
M11 N001 D VDD VDD pfet w=6u l=1u
M10 net114 net116 N002 VDD pfet w=6u l=1u
M9 net114 net74 N001 VDD pfet w=6u l=1u
M8 net116 net74 VDD VDD pfet w=6u l=1u
M7 net74 CLK_I VDD VDD pfet w=6u l=1u
M27 Q QB VSS VSS nfet w=2u l=1u
M25 QB net92 VSS VSS nfet w=2u l=1u
M23 net78 net74 N007 VSS nfet w=2u l=1u
M22 N007 net104 VSS VSS nfet w=2u l=1u
M21 net78 net116 N008 VSS nfet w=2u l=1u
M20 N008 net92 VSS VSS nfet w=2u l=1u
M19 net92 net78 VSS VSS nfet w=2u l=1u
M6 net116 net74 VSS VSS nfet w=2u l=1u
M5 net74 CLK_I VSS VSS nfet w=2u l=1u
M4 net104 net114 VSS VSS nfet w=2u l=1u
M3 N006 net104 VSS VSS nfet w=2u l=1u
M2 net114 net74 N006 VSS nfet w=2u l=1u
M1 N005 D VSS VSS nfet w=2u l=1u
M0 net114 net116 N005 VSS nfet w=2u l=1u

M_inv_p CLK_I CLK VDD VDD pfet w=6u l=1u
M_inv_n CLK_I CLK VSS VSS nfet w=2u l=1u
Mrst_m net114 RESET VSS VSS nfet w=10u l=1.5u
Mrst_s net92 RESET VSS VSS nfet w=10u l=1.5u
Mrst_p VDD RESET net104 VSS nfet w=6u l=1.5u
.ends DFFRX1
.subckt DFFRX2 VDD VSS CLK D Q QB RESET
M26 Q QB VDD VDD pfet w=6u l=1u
M24 QB net92 VDD VDD pfet w=6u l=1u
M18 net78 net116 N003 VDD pfet w=6u l=1u
M17 net78 net74 N004 VDD pfet w=6u l=1u
M16 N003 net104 VDD VDD pfet w=6u l=1u
M15 N004 net92 VDD VDD pfet w=6u l=1u
M14 net92 net78 VDD VDD pfet w=6u l=1u
M13 net104 net114 VDD VDD pfet w=6u l=1u
M12 N002 net104 VDD VDD pfet w=6u l=1u
M11 N001 D VDD VDD pfet w=6u l=1u
M10 net114 net116 N002 VDD pfet w=6u l=1u
M9 net114 net74 N001 VDD pfet w=6u l=1u
M8 net116 net74 VDD VDD pfet w=6u l=1u
M7 net74 CLK_I VDD VDD pfet w=6u l=1u
M27 Q QB VSS VSS nfet w=2u l=1u
M25 QB net92 VSS VSS nfet w=2u l=1u
M23 net78 net74 N007 VSS nfet w=2u l=1u
M22 N007 net104 VSS VSS nfet w=2u l=1u
M21 net78 net116 N008 VSS nfet w=2u l=1u
M20 N008 net92 VSS VSS nfet w=2u l=1u
M19 net92 net78 VSS VSS nfet w=2u l=1u
M6 net116 net74 VSS VSS nfet w=2u l=1u
M5 net74 CLK_I VSS VSS nfet w=2u l=1u
M4 net104 net114 VSS VSS nfet w=2u l=1u
M3 N006 net104 VSS VSS nfet w=2u l=1u
M2 net114 net74 N006 VSS nfet w=2u l=1u
M1 N005 D VSS VSS nfet w=2u l=1u
M0 net114 net116 N005 VSS nfet w=2u l=1u

M_inv_p CLK_I CLK VDD VDD pfet w=6u l=1u
M_inv_n CLK_I CLK VSS VSS nfet w=2u l=1u
Mrst_m net114 RESET VSS VSS nfet w=10u l=1.5u
Mrst_s net92 RESET VSS VSS nfet w=10u l=1.5u
Mrst_p VDD RESET net104 VSS nfet w=6u l=1.5u
Mkp net114 net104 VDD VDD pfet w=1u l=1.5u
Mkn net114 net104 VSS VSS nfet w=1u l=1.5u
.ends DFFRX2
