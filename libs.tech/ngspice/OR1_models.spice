* OR1 (OpenRule1um) ngspice device models
* Source: original work for the OR1 PDK (virtual parameters, not a foundry
*   model card).  Upstream BSIM3V3 cards live in upstream_bsim3/.
* License: Apache-2.0 (see OR1PDK/LICENSE and PROVENANCE.md).
* NOTE: tentative virtual parameters pending foundry characterization.
* Process: 1um nwell CMOS, Lmin=1um, VDD=3.3V.

.model NMOS NMOS (LEVEL=1
+ VTO=0.7 KP=110U GAMMA=0.4 LAMBDA=0.04 PHI=0.7
+ TOX=25N NSUB=1E16 LD=0.08U UO=550
+ CJ=4E-4 MJ=0.5 CJSW=1E-9 MJSW=0.33 PB=0.9
+ CGSO=3E-10 CGDO=3E-10 CGBO=1E-10
+ RSH=30 XJ=0.3U)

.model PMOS PMOS (LEVEL=1
+ VTO=-0.9 KP=40U GAMMA=0.55 LAMBDA=0.06 PHI=0.7
+ TOX=25N NSUB=6E15 LD=0.08U UO=200
+ CJ=8E-4 MJ=0.5 CJSW=2E-10 MJSW=0.33 PB=0.9
+ CGSO=3E-10 CGDO=3E-10 CGBO=1E-10
+ RSH=80 XJ=0.3U)

* Poly resistor (POL, sheet rho 20 ohm/sq - measured, not assumed:
* MakeLSI/Measure/16PTS/R-C.md, TEG 500 ohm over 45/1.8 um = 25 squares,
* confirmed within 4% by the 2022 22PTS TEG).
* NOTE: HPOL (high-res poly) is a separate process module.  The 22PTS 22HR80k
* TEG implies Rs_HPOL ~ 3.2 kohm/sq (design assumption 4.0 kohm/sq); this is a
* hypothesis pending the TEG layout.  This model does NOT cover HPOL.
* See OR1PDK/docs/measure/2026-11-01-round4-traceability-and-hpol.md.
.model rp R (RSH=20)

* Diodes (parasitic junctions)
.model DIO_N D (IS=1E-15 N=1 CJ=4E-4 MJSW=0.33 PB=0.9)
.model DIO_P D (IS=1E-15 N=1 CJ=8E-4 MJSW=0.33 PB=0.9)
